// Nanopore Spectre Netlist
// Sebastian Claudiusz Magierowski Nov 23 2025
// Resistor and Capacitor in Parallel
//
// (p) --,---------- R1 ------------,-- (n)
//       |                          |
//       '---------- C1 ------------'

simulator lang=spectre

// Subcircuit definition
subckt nanopore (p n)
  // Resistor in parallel
  R1 (p n) resistor r=1M
  // Capacitor in parallel
  C1 (p n) capacitor c=1p
ends nanopore
