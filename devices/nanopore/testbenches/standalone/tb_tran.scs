// Nanopore Transient Testbench: devices/nanopore/testbenches/standalone/tb_tran.scs
// Sebastian Claudiusz Magierowski  Nov 23 2025
//
// [V1] --- (bias) -- [XP1] -- (out) --- 0
//                      |
//                    (ctrl) -- 0
//
// Connect a pulsing voltage to cis, ground trans and ctrl and see what happens.
//
// Voltage step/pulse at bias terminal; ctrl=0 (no modulation).
// Shows RC charging behaviour through Ravg || Cmem.

simulator lang=spectre

include "../../netlist/nanopore.scs"

parameters \
    vstep = 0.5      \
    trise = 1n       \
    tfall = 1n       \
    tpw   = 100n     \
    tper  = 200n     \
    tstop = 500n     \
    tstep = 100p     \
    gv=0.5 Ravg=2.25G Rp=1 Ra=1 Cm=5p

global 0

V1  (bias 0) vsource type=pulse \
    val0=0 val1=vstep rise=trise fall=tfall width=tpw period=tper delay=0

XP1 (bias 0 0) nanopore gv=gv Ravg=Ravg Rp=Rp Ra=Ra Cm=Cm

tran1 tran stop=tstop step=tstep

save bias V1:p
saveOptions options save=selected
