// Nanopore DC I-V Testbench: devices/nanopore/testbenches/standalone/tb_iv.scs
// Sebastian Claudiusz Magierowski  Nov 23 2025
//
// [V1] --- (bias) -- [XP1] -- (out) --- 0
//                      |
//                    (ctrl) -- 0
//
// Connect a DC voltage to your cis, ground trans and ctrl and see what happens.
//
// DC sweep with ctrl=0 (baseline conductance, no modulation).
// Sweeps bias terminal from vstart to vstop; measures total pore current via I(V1).

simulator lang=spectre

include "../../netlist/nanopore.scs"

parameters vstart=-1 vstop=1 vstep=0.02 \
    gv=0.5 Ravg=2.25G Rp=1 Ra=1 Cm=5p

V1  (bias 0)       vsource dc=vstart
XP1 (bias 0 0) nanopore gv=gv Ravg=Ravg Rp=Rp Ra=Ra Cm=Cm

dc1 dc dev=V1 param=dc start=vstart stop=vstop step=vstep

save bias V1:p // I(V1) is the total pore current (positive = into device)
saveOptions options save=selected
